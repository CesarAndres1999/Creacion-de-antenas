# Ansys Electronics Desktop project, version 2018.0
materials:
  vacuum: permittivity=1
  Teflon (tm): permittivity=2.1 dielectric_loss_tangent=0.001
  air: permittivity=1.0006 permeability=1.0000004
  copper: permeability=0.999991 conductivity=58000000

design HFSSDesign1 (HFSS, DrivenModal, model units mm)
variables:
  radio1 = 0.46mm
  radio2 = 1.47mm
  lambda = 313.81mm
  adaptador = 2.5mm
  S = 84.08mm
  N = 4meter
  D = 99.89mm
  mm = 0
geometry:
  pin [copper] = cylinder(axis=Y, base_centre=((lambda/4), -lambda/4-adaptador, 0mm), radius=radio1, height=lambda/4)
  teflon [Teflon (tm)] = cylinder(axis=Y, base_centre=((lambda/4), -lambda/4-adaptador, 0mm), radius=radio2, height=lambda/4)
  pin1 = cylinder(axis=Y, base_centre=((lambda/4), -lambda /4-adaptador, 0mm), radius=radio1, height=lambda/4)
  teflon.subtract(pin1)
  Pin_conector = cylinder(axis=Y, base_centre=((lambda/4), -adaptador, 0mm), radius=radio1, height=adaptador)
  Puerto = circle(normal=Y, centre=((lambda/4), -lambda/4-adaptador, 0mm), radius=radio2)
  anillo_puerto = circle(normal=Y, centre=((lambda/4), -81.02mm, 0mm), radius=radio1)
  Puerto.subtract(anillo_puerto)
  Region [air] = region(absolute_offset=lambda/4 on all sides)
  tierra = circle(normal=Y, centre=((lambda/4), -lambda/4-adaptador, 0), radius=radio2*6)
  anillo_tierra = circle(normal=Y, centre=((lambda/4), -81.08mm, 0), radius=radio2)
  tierra.subtract(anillo_tierra)
  PolygonHelix1 [vacuum] = user_primitive(SegmentedHelix/PolygonHelix.dll, PolygonSegments=8, PolygonRadius=radio1, StartHelixRadius=D, RadiusChange=0mm, Pitch=S, Turns=4, SegmentsPerTurn=1, RightHanded=1)
  PolygonHelix1.move(lambda/4-D, 0mm, 0mm)
  PolygonHelix1.unite(Pin_conector)
boundaries and excitations:
  Conductor_externo: Perfect E Faces=teflon.face(1 of 3)
  Rad1: Radiation Objects=Region
  Conductor_interno: Perfect E Objects=pin
  tierra: Perfect E Objects=tierra
  heli: Perfect E Objects=PolygonHelix1
  1: Lumped Port Objects=Puerto Modes{Mode1{IntLine{Puerto.vertex(1 of 1) -> pin.vertex(1 of 2)} CharImp=Zpi RenormImp=50ohm}} Impedance=50ohm
setups:
  Setup1: HfssDriven Frequency=956MHz MaxDeltaS=0.02 MaximumPasses=6 MinimumPasses=1 MinimumConvergedPasses=1 PercentRefinement=30 BasisOrder=1 PortAccuracy=2
    sweep Sweep: 802MHz to 1198MHz step 22MHz; Type=Interpolating InterpTolerance=0.5 InterpMaxSolns=250 InterpUsePortImped=false PassivityErrorTolerance=0.0001
source amplitudes:
  1:1: 1W 0deg
optimetrics:
  ParametricSetup1: Parametric Sim._Setups=[Setup1]
    sweep D: LIN 89mm 110mm 4mm
    sweep S: LIN 74mm 95mm 4mm
    calculate dB(S(1,1)) on Setup1 : Sweep at Freq 0.956GHz
radiation setups:
  Infinite Sphere1: Infinite Sphere Theta=-180deg..180deg step 2deg Phi=-180deg..180deg step 2deg
reports:
  S Parameter Plot 1: dB(S(1,1)) vs Freq on Setup1 : Sweep [S=90mm D=109mm]; markers MX1 at x=9.5601137e+08
  VSWR Plot 1: VSWR(1) vs Freq on Setup1 : Sweep [S=90mm D=109mm]; markers MX1 at x=9.5601395e+08
  Gain Plot 1: GainTotal vs Theta on Setup1 : LastAdaptive, Infinite Sphere1 [Phi=-100deg Freq=0.956GHz S=84.08mm D=97mm,99.89mm]
  Z Parameter Plot 2: im(Z(1,1)) vs Freq on Setup1 : Sweep [S=84.08mm D=99.89mm]; re(Z(1,1)), im(Z(1,1)) vs Freq on Setup1 : Sweep [S=90mm D=109mm]; markers MX1 at x=9.5627194e+08
  Z Parameter Plot 3: re(Z(1,1)), im(Z(1,1)) vs Freq on Setup1 : Sweep [S=90mm D=109mm]; markers MX1 at x=9.5627857e+08
